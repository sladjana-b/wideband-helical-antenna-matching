# Ansys Electronics Desktop project, version 2018.1
materials:
  vacuum: permittivity=1
  fr4_mwo: permittivity=4.6 dielectric_loss_tangent=0.035
  copper: permeability=0.999991 conductivity=58000000

design HFSSDesign1 (HFSS, DrivenModal, model units mm)
geometry:
  Signal1_1 [copper] = imported_body(C:/Users/Lenovo/AppData/Local/Temp/20943214017825766272..sm3)
  Signal1_2..Signal1_37 = imported_body(C:/Users/Lenovo/AppData/Local/Temp/20943214017825766272..sm3)
  supstrat [fr4_mwo] = box(corner=(-60mm, -13mm, 0mm), size=(102mm, 26mm, 1.5mm))
  Signal1_1.unite(Signal1_2..Signal1_37)
  Signal1_1.thicken(0.035mm)
  Signal1_1.move(0mm, 0mm, 1.5mm)
  port1 = rectangle(corner=(-58.79mm, 1.995mm, 1.5mm), y_size=-2.71mm, z_size=-1.5mm)
  RadiatingSurface [vacuum] = region(absolute_offset=10mm on all sides)
  port2 = rectangle(corner=(41.03mm, 0.44mm, 1.5mm), y_size=0.4mm, z_size=-1.5mm)
  gnd [copper] = polyline(z=0mm, xy in mm: (-60, -8) (42, -1.5) (42, 1) (-60, 5.5) (-60, -8), closed, covered)
  gnd.thicken(-0.035mm)
  gnd.move(0mm, 1mm, 0mm)
boundaries and excitations:
  Radiation: Radiation Objects=RadiatingSurface
  1: Lumped Port Objects=port1 Modes{Mode1{IntLine{middle of port1.edge(z opposite corner) -> middle of port1.edge(z at corner)} CharImp=Zpi RenormImp=50ohm}} Impedance=50ohm
  2: Lumped Port Objects=port2 Modes{Mode1{IntLine{middle of port2.edge(z opposite corner) -> middle of port2.edge(z at corner)} CharImp=Zpi RenormImp=50ohm}} Impedance=50ohm
setups:
  Setup1: HfssDriven Frequency=10GHz MaxDeltaS=0.02 MaximumPasses=10 MinimumPasses=1 MinimumConvergedPasses=1 PercentRefinement=30 BasisOrder=1 PortAccuracy=2
    sweep Sweep: 0.5GHz to 10GHz, 451 points; Type=Interpolating InterpTolerance=0.5 InterpMaxSolns=250 InterpUsePortImped=false PassivityErrorTolerance=0.0001
source amplitudes:
  1:1: 1W 0deg
  2:1: 0W 0deg
radiation setups:
  3D: Infinite Sphere Theta=0deg..180deg step 2deg Phi=-180deg..180deg step 2deg
  Elevation: Infinite Sphere Theta=-180deg..180deg step 1deg Phi=0deg..90deg step 90deg
  Azimuth: Infinite Sphere Theta=90deg..90deg step 0deg Phi=-180deg..180deg step 1deg
reports:
  S Parameter Plot 1: dB(S(1,1)) vs Freq on Setup1 : Sweep; markers m1 at 0.83777778GHz, m2 at 1.5133333GHz, m3 at 2.8222222GHz, m4 at 3.8988889GHz, m5 at 5.1233333GHz, m6 at 6.6644444GHz, m7 at 10GHz
  S Parameter Plot 2: dB(S(2,1)) vs Freq on Setup1 : Sweep; markers m1 at 1.0277778GHz, m2 at 3.2233333GHz, m3 at 4.7222222GHz, m4 at 6.7277778GHz, m5 at 7.6777778GHz, m6 at 9.3033333GHz, m7 at 9.9788889GHz
